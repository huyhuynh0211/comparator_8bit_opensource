.include /home/huyhuynh/pdk/sky130A/libs.ref/sky130_fd_sc_hd/spice/sky130_fd_sc_hd.spice
.include /home/huyhuynh/Documents/nam3ky1/VLSIdesign/project/E2/xschem/comparator_8bit.spice
