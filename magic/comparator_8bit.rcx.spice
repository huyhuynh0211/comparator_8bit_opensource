* NGSPICE file created from comparator_8bit.ext - technology: sky130A

.subckt comparator_8bit A[0] A[1] A[2] A[3] A[4] A[5] A[6] A[7] B[0] B[1] B[2] B[3]
+ B[4] B[5] B[7] EQ GT LT VDD GND B[6]
X0 x3.S a_2283_823# VDD.t41 VDD.t36 sky130_fd_pr__pfet_01v8_hvt ad=0.165 pd=1.33 as=0.36 ps=2.72 w=1 l=0.15
X1 a_2325_911# a_2283_823# x3.S GND.t34 sky130_fd_pr__nfet_01v8 ad=0.08775 pd=0.92 as=0.195 ps=1.9 w=0.65 l=0.15
X2 x10.D a_2283_2375# VDD.t25 VDD.t24 sky130_fd_pr__pfet_01v8_hvt ad=0.165 pd=1.33 as=0.36 ps=2.72 w=1 l=0.15
X3 GND.t93 A[7] a_2325_2223# GND.t92 sky130_fd_pr__nfet_01v8 ad=0.08775 pd=0.92 as=0.169 ps=1.82 w=0.65 l=0.15
X4 VDD.t69 A[6] a_139_2223# VDD.t68 sky130_fd_pr__pfet_01v8_hvt ad=0.365 pd=1.73 as=0.135 ps=1.27 w=1 l=0.15
X5 x7.Y x6.Y a_951_2223# GND.t7 sky130_fd_pr__nfet_01v8 ad=0.08775 pd=0.92 as=0.182 ps=1.86 w=0.65 l=0.15
X6 x2.S a_2007_199# VDD.t77 VDD.t39 sky130_fd_pr__pfet_01v8_hvt ad=0.165 pd=1.33 as=0.36 ps=2.72 w=1 l=0.15
X7 x22.Y B[0] GND.t74 GND.t32 sky130_fd_pr__nfet_01v8 ad=0.08775 pd=0.92 as=0.10025 ps=0.985 w=0.65 l=0.15
X8 a_1389_1999# x10.B GND.t23 GND.t6 sky130_fd_pr__nfet_01v8 ad=0.169 pd=1.82 as=0.08775 ps=0.92 w=0.65 l=0.15
X9 x9.Y x11.Y VDD.t2 VDD.t1 sky130_fd_pr__pfet_01v8_hvt ad=0.165 pd=1.33 as=0.3 ps=2.6 w=1 l=0.15
X10 GND.t33 x2.S a_1411_47# GND.t32 sky130_fd_pr__nfet_01v8 ad=0.08775 pd=0.92 as=0.169 ps=1.82 w=0.65 l=0.15
X11 a_845_591# x4.S VDD.t37 VDD.t36 sky130_fd_pr__pfet_01v8_hvt ad=0.29 pd=2.58 as=0.26 ps=2.52 w=1 l=0.15
X12 a_2157_297# B[1] x2.S VDD.t39 sky130_fd_pr__pfet_01v8_hvt ad=0.105 pd=1.21 as=0.165 ps=1.33 w=1 l=0.15
X13 a_1957_1135# x10.A x19.B GND.t43 sky130_fd_pr__nfet_01v8 ad=0.10725 pd=0.98 as=0.195 ps=1.9 w=0.65 l=0.15
X14 VDD.t22 x10.D x19.B VDD.t21 sky130_fd_pr__pfet_01v8_hvt ad=0.26 pd=2.52 as=0.135 ps=1.27 w=1 l=0.15
X15 x10.A a_139_1999# a_377_1999# GND.t14 sky130_fd_pr__nfet_01v8 ad=0.195 pd=1.9 as=0.08775 ps=0.92 w=0.65 l=0.15
X16 GND.t60 A[4] a_221_1999# GND.t59 sky130_fd_pr__nfet_01v8 ad=0.08775 pd=0.92 as=0.06825 ps=0.86 w=0.65 l=0.15
X17 a_957_2473# B[6] x7.Y VDD.t76 sky130_fd_pr__pfet_01v8_hvt ad=0.28 pd=2.56 as=0.1525 ps=1.305 w=1 l=0.15
X18 a_1925_591# a_1581_591# VDD.t42 VDD.t36 sky130_fd_pr__pfet_01v8_hvt ad=0.1975 pd=1.395 as=0.3 ps=1.6 w=1 l=0.15
X19 a_2405_47# A[1] GND.t98 GND.t32 sky130_fd_pr__nfet_01v8 ad=0.06825 pd=0.86 as=0.08775 ps=0.92 w=0.65 l=0.15
X20 x1.Y a_810_2045# a_1001_1679# VDD.t45 sky130_fd_pr__pfet_01v8_hvt ad=0.26 pd=2.52 as=0.105 ps=1.21 w=1 l=0.15
X21 a_2681_911# A[2] GND.t86 GND.t87 sky130_fd_pr__nfet_01v8 ad=0.06825 pd=0.86 as=0.08775 ps=0.92 w=0.65 l=0.15
X22 a_581_1135# x2.S a_485_1135# GND.t46 sky130_fd_pr__nfet_01v8 ad=0.08775 pd=0.92 as=0.10725 ps=0.98 w=0.65 l=0.15
X23 VDD.t6 a_1755_2381# a_1676_2473# VDD.t5 sky130_fd_pr__pfet_01v8_hvt ad=0.3 pd=1.6 as=0.1975 ps=1.395 w=1 l=0.15
X24 GND.t9 x10.C a_951_2223# GND.t12 sky130_fd_pr__nfet_01v8 ad=0.08775 pd=0.92 as=0.169 ps=1.82 w=0.65 l=0.15
X25 x1.Y B[4] GND.t70 GND.t80 sky130_fd_pr__nfet_01v8 ad=0.08775 pd=0.92 as=0.10025 ps=0.985 w=0.65 l=0.15
X26 a_1389_1999# x1.Y x6.Y GND.t40 sky130_fd_pr__nfet_01v8 ad=0.182 pd=1.86 as=0.08775 ps=0.92 w=0.65 l=0.15
X27 a_1499_2473# x10.D VDD.t6 VDD.t18 sky130_fd_pr__pfet_01v8_hvt ad=0.26 pd=2.52 as=0.3 ps=1.6 w=1 l=0.15
X28 GND.t77 A[5] a_2049_1999# GND.t76 sky130_fd_pr__nfet_01v8 ad=0.08775 pd=0.92 as=0.169 ps=1.82 w=0.65 l=0.15
X29 x9.Y x3.S VDD.t54 VDD.t61 sky130_fd_pr__pfet_01v8_hvt ad=0.135 pd=1.27 as=0.135 ps=1.27 w=1 l=0.15
X30 a_1665_2223# x10.D GND.t5 GND.t17 sky130_fd_pr__nfet_01v8 ad=0.169 pd=1.82 as=0.08775 ps=0.92 w=0.65 l=0.15
X31 a_2053_1135# x10.B a_1957_1135# GND.t25 sky130_fd_pr__nfet_01v8 ad=0.08775 pd=0.92 as=0.10725 ps=0.98 w=0.65 l=0.15
X32 a_221_2223# B[6] a_139_2223# GND.t63 sky130_fd_pr__nfet_01v8 ad=0.06825 pd=0.86 as=0.169 ps=1.82 w=0.65 l=0.15
X33 VDD.t108 A[7] a_2433_2473# VDD.t107 sky130_fd_pr__pfet_01v8_hvt ad=0.365 pd=1.73 as=0.105 ps=1.21 w=1 l=0.15
X34 x6.Y A[5] a_1223_1679# VDD.t88 sky130_fd_pr__pfet_01v8_hvt ad=0.1525 pd=1.305 as=0.28 ps=2.56 w=1 l=0.15
X35 VDD.t84 A[0] a_317_297# VDD.t39 sky130_fd_pr__pfet_01v8_hvt ad=0.365 pd=1.73 as=0.105 ps=1.21 w=1 l=0.15
X36 x4.Y x4.A1 a_1189_591# VDD.t36 sky130_fd_pr__pfet_01v8_hvt ad=0.1525 pd=1.305 as=0.1975 ps=1.395 w=1 l=0.15
X37 a_201_1385# GT LT VDD.t99 sky130_fd_pr__pfet_01v8_hvt ad=0.105 pd=1.21 as=0.26 ps=2.52 w=1 l=0.15
X38 VDD.t103 A[3] a_139_911# VDD.t36 sky130_fd_pr__pfet_01v8_hvt ad=0.365 pd=1.73 as=0.135 ps=1.27 w=1 l=0.15
X39 VDD.t98 B[5] a_2007_1911# VDD.t97 sky130_fd_pr__pfet_01v8_hvt ad=0.3 pd=2.6 as=0.135 ps=1.27 w=1 l=0.15
X40 GND.t101 B[0] a_209_47# GND.t32 sky130_fd_pr__nfet_01v8 ad=0.169 pd=1.82 as=0.08775 ps=0.92 w=0.65 l=0.15
X41 x19.B x10.C VDD.t15 VDD.t14 sky130_fd_pr__pfet_01v8_hvt ad=0.135 pd=1.27 as=0.135 ps=1.27 w=1 l=0.15
X42 GT x4.Y a_1131_1135# GND.t0 sky130_fd_pr__nfet_01v8 ad=0.08775 pd=0.92 as=0.169 ps=1.82 w=0.65 l=0.15
X43 x4.S B[3] a_469_591# VDD.t36 sky130_fd_pr__pfet_01v8_hvt ad=0.165 pd=1.33 as=0.105 ps=1.21 w=1 l=0.15
X44 GND.t86 A[2] a_2325_911# GND.t85 sky130_fd_pr__nfet_01v8 ad=0.08775 pd=0.92 as=0.169 ps=1.82 w=0.65 l=0.15
X45 a_953_1385# x9.Y VDD.t51 VDD.t50 sky130_fd_pr__pfet_01v8_hvt ad=0.105 pd=1.21 as=0.26 ps=2.52 w=1 l=0.15
X46 a_2007_199# B[1] a_2405_47# GND.t32 sky130_fd_pr__nfet_01v8 ad=0.169 pd=1.82 as=0.06825 ps=0.86 w=0.65 l=0.15
X47 a_1693_591# B[2] x4.A1 VDD.t36 sky130_fd_pr__pfet_01v8_hvt ad=0.28 pd=2.56 as=0.1525 ps=1.305 w=1 l=0.15
X48 a_1400_1679# x1.Y x6.Y VDD.t44 sky130_fd_pr__pfet_01v8_hvt ad=0.1975 pd=1.395 as=0.1525 ps=1.305 w=1 l=0.15
X49 VDD.t63 a_139_911# x4.S VDD.t36 sky130_fd_pr__pfet_01v8_hvt ad=0.36 pd=2.72 as=0.165 ps=1.33 w=1 l=0.15
X50 a_1665_2223# x7.Y x20.A1 GND.t6 sky130_fd_pr__nfet_01v8 ad=0.182 pd=1.86 as=0.08775 ps=0.92 w=0.65 l=0.15
X51 VDD.t47 a_139_1999# x10.A VDD.t46 sky130_fd_pr__pfet_01v8_hvt ad=0.36 pd=2.72 as=0.165 ps=1.33 w=1 l=0.15
X52 a_1577_47# a_1305_47# GND.t33 GND.t32 sky130_fd_pr__nfet_01v8 ad=0.169 pd=1.82 as=0.08775 ps=0.92 w=0.65 l=0.15
X53 x7.Y x6.Y a_1189_2473# VDD.t8 sky130_fd_pr__pfet_01v8_hvt ad=0.1525 pd=1.305 as=0.1975 ps=1.395 w=1 l=0.15
X54 a_1581_591# x3.S VDD.t60 VDD.t36 sky130_fd_pr__pfet_01v8_hvt ad=0.29 pd=2.58 as=0.26 ps=2.52 w=1 l=0.15
X55 x10.C B[6] a_469_2473# VDD.t75 sky130_fd_pr__pfet_01v8_hvt ad=0.165 pd=1.33 as=0.105 ps=1.21 w=1 l=0.15
X56 x10.C a_139_2223# a_377_2223# GND.t14 sky130_fd_pr__nfet_01v8 ad=0.195 pd=1.9 as=0.08775 ps=0.92 w=0.65 l=0.15
X57 a_1577_47# A[1] x2.Y GND.t32 sky130_fd_pr__nfet_01v8 ad=0.169 pd=1.82 as=0.08775 ps=0.92 w=0.65 l=0.15
X58 VDD.t10 x10.C a_957_2473# VDD.t13 sky130_fd_pr__pfet_01v8_hvt ad=0.3 pd=1.6 as=0.26 ps=2.52 w=1 l=0.15
X59 a_2283_2375# A[7] VDD.t106 VDD.t105 sky130_fd_pr__pfet_01v8_hvt ad=0.135 pd=1.27 as=0.365 ps=1.73 w=1 l=0.15
X60 GND.t60 A[6] a_221_2223# GND.t59 sky130_fd_pr__nfet_01v8 ad=0.08775 pd=0.92 as=0.06825 ps=0.86 w=0.65 l=0.15
X61 VDD.t114 B[0] a_167_199# VDD.t39 sky130_fd_pr__pfet_01v8_hvt ad=0.3 pd=2.6 as=0.135 ps=1.27 w=1 l=0.15
X62 a_139_911# B[3] VDD.t109 VDD.t36 sky130_fd_pr__pfet_01v8_hvt ad=0.135 pd=1.27 as=0.3 ps=2.6 w=1 l=0.15
X63 a_1853_911# B[2] x4.A1 GND.t103 sky130_fd_pr__nfet_01v8 ad=0.169 pd=1.82 as=0.08775 ps=0.92 w=0.65 l=0.15
X64 a_957_591# A[3] x4.Y VDD.t36 sky130_fd_pr__pfet_01v8_hvt ad=0.28 pd=2.56 as=0.1525 ps=1.305 w=1 l=0.15
X65 a_485_1135# x11.Y x9.Y GND.t1 sky130_fd_pr__nfet_01v8 ad=0.10725 pd=0.98 as=0.195 ps=1.9 w=0.65 l=0.15
X66 VDD.t113 EQ a_201_1385# VDD.t112 sky130_fd_pr__pfet_01v8_hvt ad=0.26 pd=2.52 as=0.105 ps=1.21 w=1 l=0.15
X67 x11.Y a_167_199# VDD.t43 VDD.t39 sky130_fd_pr__pfet_01v8_hvt ad=0.165 pd=1.33 as=0.36 ps=2.72 w=1 l=0.15
X68 GND.t19 x10.D a_2137_1135# GND.t18 sky130_fd_pr__nfet_01v8 ad=0.169 pd=1.82 as=0.08775 ps=0.92 w=0.65 l=0.15
X69 EQ x9.Y GND.t45 GND.t44 sky130_fd_pr__nfet_01v8 ad=0.08775 pd=0.92 as=0.169 ps=1.82 w=0.65 l=0.15
X70 a_2157_1679# B[5] x10.B VDD.t96 sky130_fd_pr__pfet_01v8_hvt ad=0.105 pd=1.21 as=0.165 ps=1.33 w=1 l=0.15
X71 a_1117_911# A[3] x4.Y GND.t91 sky130_fd_pr__nfet_01v8 ad=0.169 pd=1.82 as=0.08775 ps=0.92 w=0.65 l=0.15
X72 a_2325_2223# a_2283_2375# x10.D GND.t21 sky130_fd_pr__nfet_01v8 ad=0.08775 pd=0.92 as=0.195 ps=1.9 w=0.65 l=0.15
X73 GND.t5 x10.B a_1479_1653# GND.t24 sky130_fd_pr__nfet_01v8 ad=0.169 pd=1.82 as=0.169 ps=1.82 w=0.65 l=0.15
X74 a_469_1679# A[4] VDD.t81 VDD.t82 sky130_fd_pr__pfet_01v8_hvt ad=0.105 pd=1.21 as=0.365 ps=1.73 w=1 l=0.15
X75 a_1305_47# x2.S VDD.t52 VDD.t39 sky130_fd_pr__pfet_01v8_hvt ad=0.29 pd=2.58 as=0.26 ps=2.52 w=1 l=0.15
X76 x4.A1 x2.Y a_1925_591# VDD.t36 sky130_fd_pr__pfet_01v8_hvt ad=0.1525 pd=1.305 as=0.1975 ps=1.395 w=1 l=0.15
X77 x22.Y a_810_47# a_1001_297# VDD.t39 sky130_fd_pr__pfet_01v8_hvt ad=0.26 pd=2.52 as=0.105 ps=1.21 w=1 l=0.15
X78 VDD.t87 A[0] a_810_47# VDD.t86 sky130_fd_pr__pfet_01v8_hvt ad=0.1573 pd=1.39 as=0.1092 ps=1.36 w=0.42 l=0.15
X79 a_317_297# B[0] x11.Y VDD.t39 sky130_fd_pr__pfet_01v8_hvt ad=0.105 pd=1.21 as=0.165 ps=1.33 w=1 l=0.15
X80 a_167_199# A[0] VDD.t84 VDD.t39 sky130_fd_pr__pfet_01v8_hvt ad=0.135 pd=1.27 as=0.365 ps=1.73 w=1 l=0.15
X81 a_845_591# x4.S GND.t28 GND.t27 sky130_fd_pr__nfet_01v8 ad=0.169 pd=1.82 as=0.169 ps=1.82 w=0.65 l=0.15
X82 a_1649_297# a_1305_47# VDD.t40 VDD.t39 sky130_fd_pr__pfet_01v8_hvt ad=0.1975 pd=1.395 as=0.3 ps=1.6 w=1 l=0.15
X83 a_377_1999# A[4] GND.t60 GND.t61 sky130_fd_pr__nfet_01v8 ad=0.169 pd=1.82 as=0.08775 ps=0.92 w=0.65 l=0.15
X84 a_1676_2473# x7.Y x20.A1 VDD.t7 sky130_fd_pr__pfet_01v8_hvt ad=0.1975 pd=1.395 as=0.1525 ps=1.305 w=1 l=0.15
X85 VDD.t4 a_1387_1293# a_1308_1385# VDD.t3 sky130_fd_pr__pfet_01v8_hvt ad=0.3 pd=1.6 as=0.1975 ps=1.395 w=1 l=0.15
X86 a_139_2223# B[6] VDD.t74 VDD.t73 sky130_fd_pr__pfet_01v8_hvt ad=0.135 pd=1.27 as=0.3 ps=2.6 w=1 l=0.15
X87 a_1131_1385# x19.B VDD.t4 VDD.t59 sky130_fd_pr__pfet_01v8_hvt ad=0.26 pd=2.52 as=0.3 ps=1.6 w=1 l=0.15
X88 a_209_47# a_167_199# x11.Y GND.t32 sky130_fd_pr__nfet_01v8 ad=0.08775 pd=0.92 as=0.195 ps=1.9 w=0.65 l=0.15
X89 GND.t71 B[1] a_2049_47# GND.t32 sky130_fd_pr__nfet_01v8 ad=0.169 pd=1.82 as=0.08775 ps=0.92 w=0.65 l=0.15
X90 a_469_591# A[3] VDD.t103 VDD.t36 sky130_fd_pr__pfet_01v8_hvt ad=0.105 pd=1.21 as=0.365 ps=1.73 w=1 l=0.15
X91 a_1297_1135# x19.B GND.t3 GND.t50 sky130_fd_pr__nfet_01v8 ad=0.169 pd=1.82 as=0.08775 ps=0.92 w=0.65 l=0.15
X92 a_665_1135# x3.S a_581_1135# GND.t52 sky130_fd_pr__nfet_01v8 ad=0.08775 pd=0.92 as=0.08775 ps=0.92 w=0.65 l=0.15
X93 a_1001_297# B[0] VDD.t87 VDD.t39 sky130_fd_pr__pfet_01v8_hvt ad=0.105 pd=1.21 as=0.1573 ps=1.39 w=1 l=0.15
X94 a_1117_911# a_845_591# GND.t31 GND.t62 sky130_fd_pr__nfet_01v8 ad=0.169 pd=1.82 as=0.08775 ps=0.92 w=0.65 l=0.15
X95 x4.Y x4.A1 a_951_911# GND.t38 sky130_fd_pr__nfet_01v8 ad=0.08775 pd=0.92 as=0.182 ps=1.86 w=0.65 l=0.15
X96 a_2405_1999# A[5] GND.t77 GND.t78 sky130_fd_pr__nfet_01v8 ad=0.06825 pd=0.86 as=0.08775 ps=0.92 w=0.65 l=0.15
X97 VDD.t81 A[4] a_139_1999# VDD.t80 sky130_fd_pr__pfet_01v8_hvt ad=0.365 pd=1.73 as=0.135 ps=1.27 w=1 l=0.15
X98 VDD.t58 x19.B a_1387_1293# VDD.t57 sky130_fd_pr__pfet_01v8_hvt ad=0.26 pd=2.52 as=0.29 ps=2.58 w=1 l=0.15
X99 VDD.t35 x4.S x9.Y VDD.t34 sky130_fd_pr__pfet_01v8_hvt ad=0.26 pd=2.52 as=0.135 ps=1.27 w=1 l=0.15
X100 a_377_911# A[3] GND.t89 GND.t90 sky130_fd_pr__nfet_01v8 ad=0.169 pd=1.82 as=0.08775 ps=0.92 w=0.65 l=0.15
X101 LT GT GND.t84 GND.t83 sky130_fd_pr__nfet_01v8 ad=0.08775 pd=0.92 as=0.169 ps=1.82 w=0.65 l=0.15
X102 VDD.t38 x4.S a_957_591# VDD.t36 sky130_fd_pr__pfet_01v8_hvt ad=0.3 pd=1.6 as=0.26 ps=2.52 w=1 l=0.15
X103 a_2137_1135# x10.C a_2053_1135# GND.t13 sky130_fd_pr__nfet_01v8 ad=0.08775 pd=0.92 as=0.08775 ps=0.92 w=0.65 l=0.15
X104 x2.Y x22.Y a_1411_47# GND.t32 sky130_fd_pr__nfet_01v8 ad=0.08775 pd=0.92 as=0.182 ps=1.86 w=0.65 l=0.15
X105 VDD.t20 x10.D a_1755_2381# VDD.t19 sky130_fd_pr__pfet_01v8_hvt ad=0.26 pd=2.52 as=0.29 ps=2.58 w=1 l=0.15
X106 a_845_2223# x10.C VDD.t12 VDD.t11 sky130_fd_pr__pfet_01v8_hvt ad=0.29 pd=2.58 as=0.26 ps=2.52 w=1 l=0.15
X107 a_1297_1135# x20.A1 GT GND.t20 sky130_fd_pr__nfet_01v8 ad=0.182 pd=1.86 as=0.08775 ps=0.92 w=0.65 l=0.15
X108 VDD.t101 A[2] a_2433_591# VDD.t36 sky130_fd_pr__pfet_01v8_hvt ad=0.365 pd=1.73 as=0.105 ps=1.21 w=1 l=0.15
X109 GND.t89 A[3] a_221_911# GND.t88 sky130_fd_pr__nfet_01v8 ad=0.08775 pd=0.92 as=0.06825 ps=0.86 w=0.65 l=0.15
X110 a_1189_2473# a_845_2223# VDD.t10 VDD.t9 sky130_fd_pr__pfet_01v8_hvt ad=0.1975 pd=1.395 as=0.3 ps=1.6 w=1 l=0.15
X111 GND.t5 a_1755_2381# a_1499_2223# GND.t4 sky130_fd_pr__nfet_01v8 ad=0.08775 pd=0.92 as=0.169 ps=1.82 w=0.65 l=0.15
X112 GND.t16 B[5] a_2049_1999# GND.t81 sky130_fd_pr__nfet_01v8 ad=0.169 pd=1.82 as=0.08775 ps=0.92 w=0.65 l=0.15
X113 GND.t72 A[0] a_209_47# GND.t32 sky130_fd_pr__nfet_01v8 ad=0.08775 pd=0.92 as=0.169 ps=1.82 w=0.65 l=0.15
X114 a_2681_2223# A[7] GND.t93 GND.t94 sky130_fd_pr__nfet_01v8 ad=0.06825 pd=0.86 as=0.08775 ps=0.92 w=0.65 l=0.15
X115 a_1117_2223# B[6] x7.Y GND.t66 sky130_fd_pr__nfet_01v8 ad=0.169 pd=1.82 as=0.08775 ps=0.92 w=0.65 l=0.15
X116 a_2007_1911# B[5] a_2405_1999# GND.t82 sky130_fd_pr__nfet_01v8 ad=0.169 pd=1.82 as=0.06825 ps=0.86 w=0.65 l=0.15
X117 VDD.t110 A[1] a_2157_297# VDD.t39 sky130_fd_pr__pfet_01v8_hvt ad=0.365 pd=1.73 as=0.105 ps=1.21 w=1 l=0.15
X118 x20.A1 B[7] a_1499_2473# VDD.t64 sky130_fd_pr__pfet_01v8_hvt ad=0.1525 pd=1.305 as=0.28 ps=2.56 w=1 l=0.15
X119 EQ x19.B a_953_1385# VDD.t56 sky130_fd_pr__pfet_01v8_hvt ad=0.26 pd=2.52 as=0.105 ps=1.21 w=1 l=0.15
X120 x4.A1 x2.Y a_1687_911# GND.t35 sky130_fd_pr__nfet_01v8 ad=0.08775 pd=0.92 as=0.182 ps=1.86 w=0.65 l=0.15
X121 VDD.t67 B[7] a_2283_2375# VDD.t66 sky130_fd_pr__pfet_01v8_hvt ad=0.3 pd=2.6 as=0.135 ps=1.27 w=1 l=0.15
X122 a_377_2223# A[6] GND.t60 GND.t61 sky130_fd_pr__nfet_01v8 ad=0.169 pd=1.82 as=0.08775 ps=0.92 w=0.65 l=0.15
X123 a_2049_47# a_2007_199# x2.S GND.t32 sky130_fd_pr__nfet_01v8 ad=0.08775 pd=0.92 as=0.195 ps=1.9 w=0.65 l=0.15
X124 a_1305_47# x2.S GND.t47 GND.t32 sky130_fd_pr__nfet_01v8 ad=0.169 pd=1.82 as=0.169 ps=1.82 w=0.65 l=0.15
X125 a_1581_591# x3.S GND.t3 GND.t53 sky130_fd_pr__nfet_01v8 ad=0.169 pd=1.82 as=0.169 ps=1.82 w=0.65 l=0.15
X126 VDD.t42 x3.S a_1693_591# VDD.t36 sky130_fd_pr__pfet_01v8_hvt ad=0.3 pd=1.6 as=0.26 ps=2.52 w=1 l=0.15
X127 x2.Y x22.Y a_1649_297# VDD.t39 sky130_fd_pr__pfet_01v8_hvt ad=0.1525 pd=1.305 as=0.1975 ps=1.395 w=1 l=0.15
X128 VDD.t117 B[2] a_2283_823# VDD.t116 sky130_fd_pr__pfet_01v8_hvt ad=0.3 pd=2.6 as=0.135 ps=1.27 w=1 l=0.15
X129 GND.t57 B[7] a_2325_2223# GND.t56 sky130_fd_pr__nfet_01v8 ad=0.169 pd=1.82 as=0.08775 ps=0.92 w=0.65 l=0.15
X130 GND.t42 a_810_2045# x1.Y GND.t41 sky130_fd_pr__nfet_01v8 ad=0.169 pd=1.82 as=0.08775 ps=0.92 w=0.65 l=0.15
X131 GND.t23 a_1479_1653# a_1223_1999# GND.t26 sky130_fd_pr__nfet_01v8 ad=0.08775 pd=0.92 as=0.169 ps=1.82 w=0.65 l=0.15
X132 VDD.t29 a_1479_1653# a_1400_1679# VDD.t33 sky130_fd_pr__pfet_01v8_hvt ad=0.3 pd=1.6 as=0.1975 ps=1.395 w=1 l=0.15
X133 a_1308_1385# x20.A1 GT VDD.t23 sky130_fd_pr__pfet_01v8_hvt ad=0.1975 pd=1.395 as=0.1525 ps=1.305 w=1 l=0.15
X134 GND.t39 a_810_47# x22.Y GND.t32 sky130_fd_pr__nfet_01v8 ad=0.169 pd=1.82 as=0.08775 ps=0.92 w=0.65 l=0.15
X135 a_1223_1679# x10.B VDD.t29 VDD.t28 sky130_fd_pr__pfet_01v8_hvt ad=0.26 pd=2.52 as=0.3 ps=1.6 w=1 l=0.15
X136 GND.t74 A[0] a_810_47# GND.t32 sky130_fd_pr__nfet_01v8 ad=0.10025 pd=0.985 as=0.1092 ps=1.36 w=0.42 l=0.15
X137 x4.S a_139_911# a_377_911# GND.t55 sky130_fd_pr__nfet_01v8 ad=0.195 pd=1.9 as=0.08775 ps=0.92 w=0.65 l=0.15
X138 a_1117_2223# a_845_2223# GND.t9 GND.t8 sky130_fd_pr__nfet_01v8 ad=0.169 pd=1.82 as=0.08775 ps=0.92 w=0.65 l=0.15
X139 VDD.t40 x2.S a_1417_297# VDD.t39 sky130_fd_pr__pfet_01v8_hvt ad=0.3 pd=1.6 as=0.26 ps=2.52 w=1 l=0.15
X140 a_377_1999# B[4] GND.t65 GND.t64 sky130_fd_pr__nfet_01v8 ad=0.08775 pd=0.92 as=0.169 ps=1.82 w=0.65 l=0.15
X141 a_221_911# B[3] a_139_911# GND.t95 sky130_fd_pr__nfet_01v8 ad=0.06825 pd=0.86 as=0.169 ps=1.82 w=0.65 l=0.15
X142 VDD.t79 A[4] a_810_2045# VDD.t78 sky130_fd_pr__pfet_01v8_hvt ad=0.1573 pd=1.39 as=0.1092 ps=1.36 w=0.42 l=0.15
X143 VDD.t90 A[5] a_2157_1679# VDD.t89 sky130_fd_pr__pfet_01v8_hvt ad=0.365 pd=1.73 as=0.105 ps=1.21 w=1 l=0.15
X144 VDD.t83 B[1] a_2007_199# VDD.t39 sky130_fd_pr__pfet_01v8_hvt ad=0.3 pd=2.6 as=0.135 ps=1.27 w=1 l=0.15
X145 a_2283_2375# B[7] a_2681_2223# GND.t58 sky130_fd_pr__nfet_01v8 ad=0.169 pd=1.82 as=0.06825 ps=0.86 w=0.65 l=0.15
X146 a_2283_823# A[2] VDD.t101 VDD.t100 sky130_fd_pr__pfet_01v8_hvt ad=0.135 pd=1.27 as=0.365 ps=1.73 w=1 l=0.15
X147 x10.A B[4] a_469_1679# VDD.t94 sky130_fd_pr__pfet_01v8_hvt ad=0.165 pd=1.33 as=0.105 ps=1.21 w=1 l=0.15
X148 VDD.t31 x10.B a_1479_1653# VDD.t30 sky130_fd_pr__pfet_01v8_hvt ad=0.26 pd=2.52 as=0.29 ps=2.58 w=1 l=0.15
X149 x19.B x10.A VDD.t49 VDD.t48 sky130_fd_pr__pfet_01v8_hvt ad=0.165 pd=1.33 as=0.3 ps=2.6 w=1 l=0.15
X150 GND.t37 x19.B a_1387_1293# GND.t49 sky130_fd_pr__nfet_01v8 ad=0.169 pd=1.82 as=0.169 ps=1.82 w=0.65 l=0.15
X151 GND.t28 x4.S a_665_1135# GND.t29 sky130_fd_pr__nfet_01v8 ad=0.169 pd=1.82 as=0.08775 ps=0.92 w=0.65 l=0.15
X152 a_2433_2473# B[7] x10.D VDD.t65 sky130_fd_pr__pfet_01v8_hvt ad=0.105 pd=1.21 as=0.165 ps=1.33 w=1 l=0.15
X153 GND.t31 x4.S a_951_911# GND.t30 sky130_fd_pr__nfet_01v8 ad=0.08775 pd=0.92 as=0.169 ps=1.82 w=0.65 l=0.15
X154 a_377_911# B[3] GND.t97 GND.t96 sky130_fd_pr__nfet_01v8 ad=0.08775 pd=0.92 as=0.169 ps=1.82 w=0.65 l=0.15
X155 GND.t70 A[4] a_810_2045# GND.t69 sky130_fd_pr__nfet_01v8 ad=0.10025 pd=0.985 as=0.1092 ps=1.36 w=0.42 l=0.15
X156 x6.Y A[5] a_1223_1999# GND.t75 sky130_fd_pr__nfet_01v8 ad=0.08775 pd=0.92 as=0.169 ps=1.82 w=0.65 l=0.15
X157 a_2007_199# A[1] VDD.t110 VDD.t39 sky130_fd_pr__pfet_01v8_hvt ad=0.135 pd=1.27 as=0.365 ps=1.73 w=1 l=0.15
X158 a_1417_297# A[1] x2.Y VDD.t39 sky130_fd_pr__pfet_01v8_hvt ad=0.28 pd=2.56 as=0.1525 ps=1.305 w=1 l=0.15
X159 VDD.t17 a_139_2223# x10.C VDD.t16 sky130_fd_pr__pfet_01v8_hvt ad=0.36 pd=2.72 as=0.165 ps=1.33 w=1 l=0.15
X160 GND.t16 x10.D a_1755_2381# GND.t15 sky130_fd_pr__nfet_01v8 ad=0.169 pd=1.82 as=0.169 ps=1.82 w=0.65 l=0.15
X161 VDD.t54 x2.S x9.Y VDD.t53 sky130_fd_pr__pfet_01v8_hvt ad=0.135 pd=1.27 as=0.165 ps=1.33 w=1 l=0.15
X162 GND.t89 EQ LT GND.t100 sky130_fd_pr__nfet_01v8 ad=0.169 pd=1.82 as=0.08775 ps=0.92 w=0.65 l=0.15
X163 x10.B a_2007_1911# VDD.t27 VDD.t26 sky130_fd_pr__pfet_01v8_hvt ad=0.165 pd=1.33 as=0.36 ps=2.72 w=1 l=0.15
X164 a_565_47# A[0] GND.t72 GND.t32 sky130_fd_pr__nfet_01v8 ad=0.06825 pd=0.86 as=0.08775 ps=0.92 w=0.65 l=0.15
X165 a_845_2223# x10.C GND.t11 GND.t10 sky130_fd_pr__nfet_01v8 ad=0.169 pd=1.82 as=0.169 ps=1.82 w=0.65 l=0.15
X166 GND.t3 a_1387_1293# a_1131_1135# GND.t2 sky130_fd_pr__nfet_01v8 ad=0.08775 pd=0.92 as=0.169 ps=1.82 w=0.65 l=0.15
X167 GND.t98 A[1] a_2049_47# GND.t32 sky130_fd_pr__nfet_01v8 ad=0.08775 pd=0.92 as=0.169 ps=1.82 w=0.65 l=0.15
X168 a_2007_1911# A[5] VDD.t90 VDD.t91 sky130_fd_pr__pfet_01v8_hvt ad=0.135 pd=1.27 as=0.365 ps=1.73 w=1 l=0.15
X169 VDD.t15 x10.B x19.B VDD.t32 sky130_fd_pr__pfet_01v8_hvt ad=0.135 pd=1.27 as=0.165 ps=1.33 w=1 l=0.15
X170 a_1853_911# a_1581_591# GND.t37 GND.t36 sky130_fd_pr__nfet_01v8 ad=0.169 pd=1.82 as=0.08775 ps=0.92 w=0.65 l=0.15
X171 a_139_1999# B[4] VDD.t93 VDD.t92 sky130_fd_pr__pfet_01v8_hvt ad=0.135 pd=1.27 as=0.3 ps=2.6 w=1 l=0.15
X172 a_469_2473# A[6] VDD.t71 VDD.t70 sky130_fd_pr__pfet_01v8_hvt ad=0.105 pd=1.21 as=0.365 ps=1.73 w=1 l=0.15
X173 GT x4.Y a_1131_1385# VDD.t0 sky130_fd_pr__pfet_01v8_hvt ad=0.1525 pd=1.305 as=0.28 ps=2.56 w=1 l=0.15
X174 a_1189_591# a_845_591# VDD.t38 VDD.t36 sky130_fd_pr__pfet_01v8_hvt ad=0.1975 pd=1.395 as=0.3 ps=1.6 w=1 l=0.15
X175 GND.t105 B[2] a_2325_911# GND.t104 sky130_fd_pr__nfet_01v8 ad=0.169 pd=1.82 as=0.08775 ps=0.92 w=0.65 l=0.15
X176 GND.t31 x19.B EQ GND.t51 sky130_fd_pr__nfet_01v8 ad=0.169 pd=1.82 as=0.08775 ps=0.92 w=0.65 l=0.15
X177 x20.A1 B[7] a_1499_2223# GND.t26 sky130_fd_pr__nfet_01v8 ad=0.08775 pd=0.92 as=0.169 ps=1.82 w=0.65 l=0.15
X178 a_221_1999# B[4] a_139_1999# GND.t63 sky130_fd_pr__nfet_01v8 ad=0.06825 pd=0.86 as=0.169 ps=1.82 w=0.65 l=0.15
X179 a_2283_823# B[2] a_2681_911# GND.t106 sky130_fd_pr__nfet_01v8 ad=0.169 pd=1.82 as=0.06825 ps=0.86 w=0.65 l=0.15
X180 a_377_2223# B[6] GND.t65 GND.t64 sky130_fd_pr__nfet_01v8 ad=0.08775 pd=0.92 as=0.169 ps=1.82 w=0.65 l=0.15
X181 a_2049_1999# a_2007_1911# x10.B GND.t22 sky130_fd_pr__nfet_01v8 ad=0.08775 pd=0.92 as=0.195 ps=1.9 w=0.65 l=0.15
X182 a_167_199# B[0] a_565_47# GND.t32 sky130_fd_pr__nfet_01v8 ad=0.169 pd=1.82 as=0.06825 ps=0.86 w=0.65 l=0.15
X183 a_2433_591# B[2] x3.S VDD.t36 sky130_fd_pr__pfet_01v8_hvt ad=0.105 pd=1.21 as=0.165 ps=1.33 w=1 l=0.15
X184 a_1001_1679# B[4] VDD.t79 VDD.t95 sky130_fd_pr__pfet_01v8_hvt ad=0.105 pd=1.21 as=0.1573 ps=1.39 w=1 l=0.15
X185 GND.t37 x3.S a_1687_911# GND.t54 sky130_fd_pr__nfet_01v8 ad=0.08775 pd=0.92 as=0.169 ps=1.82 w=0.65 l=0.15
R0 VDD.n33 VDD.t73 651.125
R1 VDD.t16 VDD.t11 615.577
R2 VDD.t19 VDD.t24 615.577
R3 VDD.n3 VDD.n2 274.997
R4 VDD.n17 VDD.t71 585
R5 VDD.t69 VDD.n32 585
R6 VDD.t76 VDD.t64 580.062
R7 VDD.t11 VDD.t13 574.144
R8 VDD.t18 VDD.t19 574.144
R9 VDD.t68 VDD.t70 520.872
R10 VDD.t107 VDD.t105 520.872
R11 VDD.t13 VDD.t9 443.925
R12 VDD.t5 VDD.t18 443.925
R13 VDD.t89 VDD.t91 362.022
R14 VDD.n39 VDD.t99 341.543
R15 VDD.t9 VDD.t8 322.587
R16 VDD.t7 VDD.t5 322.587
R17 VDD.t80 VDD.t82 295.406
R18 VDD.t75 VDD.t16 284.113
R19 VDD.t24 VDD.t65 284.113
R20 VDD.t8 VDD.t76 269.315
R21 VDD.t64 VDD.t7 269.315
R22 VDD.t100 VDD.t116 248.599
R23 VDD.t91 VDD.t97 248.599
R24 VDD.t73 VDD.t68 248.599
R25 VDD.t105 VDD.t66 248.599
R26 VDD.t34 VDD.t78 241.696
R27 VDD.t45 VDD.t0 241.696
R28 VDD.t70 VDD.t75 213.084
R29 VDD.t65 VDD.t107 213.084
R30 VDD.t30 VDD.t48 174.559
R31 VDD.t28 VDD.t57 171.202
R32 VDD.t48 VDD.t32 161.131
R33 VDD.t3 VDD.t33 154.417
R34 VDD.t59 VDD.t28 154.417
R35 VDD.t57 VDD.t30 154.417
R36 VDD.n44 VDD.t100 153.894
R37 VDD.t0 VDD.t23 152.739
R38 VDD.t88 VDD.t44 152.739
R39 VDD.t61 VDD.t34 140.989
R40 VDD.t26 VDD.t14 127.562
R41 VDD.t92 VDD.t112 107.421
R42 VDD.t96 VDD.t21 107.421
R43 VDD.t78 VDD.t50 100.707
R44 VDD.n44 VDD.t39 99.8247
R45 VDD.t33 VDD.t59 97.3503
R46 VDD.t1 VDD.t94 93.9934
R47 VDD.t53 VDD.t46 93.9934
R48 VDD.t71 VDD.t69 90.6205
R49 VDD.n3 VDD.t106 42.0651
R50 VDD.t50 VDD.t95 80.5659
R51 VDD.t56 VDD.t45 80.5659
R52 VDD.t94 VDD.t53 67.1383
R53 VDD.t46 VDD.t61 46.997
R54 VDD.t95 VDD.t56 40.2832
R55 VDD.t84 VDD.n6 22.6164
R56 VDD.n8 VDD.t83 7.5595
R57 VDD.t52 VDD.n15 30.298
R58 VDD.n41 VDD.n23 40.6869
R59 VDD.n10 VDD.n8 1.57462
R60 VDD.t79 VDD.n13 15.8346
R61 VDD.t6 VDD.n12 7.89488
R62 VDD.t10 VDD.n11 7.6852
R63 VDD.n11 VDD.t12 30.841
R64 VDD.t112 VDD.t80 33.5694
R65 VDD.t14 VDD.t96 33.5694
R66 VDD.t2 VDD.n25 39.5575
R67 VDD.t43 VDD.n19 38.8046
R68 VDD.n6 VDD.t63 38.8046
R69 VDD.n24 VDD.t113 37.5158
R70 VDD.n28 VDD.t15 36.9222
R71 VDD.n7 VDD.t25 3.32868
R72 VDD.n17 VDD.n30 36.4517
R73 VDD.n29 VDD.n32 34.2216
R74 VDD.t44 VDD.t3 28.5341
R75 VDD.t82 VDD.t1 26.8556
R76 VDD.n10 VDD.t77 4.26829
R77 VDD.n42 VDD.t37 24.0946
R78 VDD.n22 VDD.t52 5.24939
R79 VDD.t79 VDD.t51 24.0946
R80 VDD.t49 VDD.t27 24.0946
R81 VDD.t101 VDD.t117 23.7762
R82 VDD.t90 VDD.t98 23.7762
R83 VDD.n44 VDD.n18 395.039
R84 VDD.t35 VDD.n36 23.7181
R85 VDD.t58 VDD.t31 23.3417
R86 VDD.n1 VDD.t58 6.75715
R87 VDD.t20 VDD.n12 30.6322
R88 VDD.t39 VDD.t86 21.5239
R89 VDD.t17 VDD.n30 27.5105
R90 VDD.t40 VDD.n41 18.824
R91 VDD.n43 VDD.t103 18.0711
R92 VDD.n43 VDD.t84 18.0711
R93 VDD.t83 VDD.t101 18.0711
R94 VDD.t81 VDD.n37 18.0711
R95 VDD.t47 VDD.t54 17.6946
R96 VDD.t22 VDD.t90 16.9417
R97 VDD.t103 VDD.n19 22.6164
R98 VDD.n9 VDD.n8 4.46624
R99 VDD.n38 VDD.t81 16.5652
R100 VDD.n26 VDD.t35 4.38186
R101 VDD.n9 VDD.t110 7.84587
R102 VDD.t60 VDD.t40 15.4358
R103 VDD.t20 VDD.n7 4.40488
R104 VDD.n31 VDD.t12 4.10365
R105 VDD.n20 VDD.t87 19.0687
R106 VDD.t99 VDD.t92 13.4281
R107 VDD.t32 VDD.t26 13.4281
R108 VDD.t21 VDD.t89 13.4281
R109 VDD.n39 VDD.t93 12.8005
R110 VDD.n33 VDD.t74 12.8005
R111 VDD.t38 VDD.n22 15.4141
R112 VDD.t42 VDD.n10 15.8116
R113 VDD.n13 VDD.t4 18.1758
R114 VDD.n35 VDD.t29 10.1652
R115 VDD.n5 VDD.n19 1.62567
R116 VDD.n5 VDD.n43 9.3005
R117 VDD.n6 VDD.n5 1.62567
R118 VDD.n5 VDD.n42 9.3005
R119 VDD.t37 VDD.n20 5.1393
R120 VDD.n20 VDD.n5 2.08185
R121 VDD.n21 VDD.t87 5.77756
R122 VDD.n4 VDD.n21 1.76272
R123 VDD.n22 VDD.n4 2.02681
R124 VDD.n14 VDD.n15 0.293843
R125 VDD.n41 VDD.n14 9.3005
R126 VDD.n8 VDD.n23 1.62567
R127 VDD.n5 VDD.n18 2.04483
R128 VDD.t93 VDD.n24 5.1393
R129 VDD.n24 VDD.n0 2.08185
R130 VDD.n0 VDD.n38 9.3005
R131 VDD.n37 VDD.n0 9.3005
R132 VDD.n0 VDD.n25 1.62567
R133 VDD.n26 VDD.t47 4.38186
R134 VDD.n26 VDD.n0 2.46057
R135 VDD.n36 VDD.n0 9.3005
R136 VDD.n35 VDD.n0 9.3005
R137 VDD.n1 VDD.n0 0.379411
R138 VDD.n0 VDD.n34 9.3005
R139 VDD.t27 VDD.n27 4.98285
R140 VDD.n27 VDD.n0 2.16007
R141 VDD.n28 VDD.n0 1.62567
R142 VDD.n0 VDD.n39 9.3005
R143 VDD.n2 VDD.n33 9.3005
R144 VDD.t74 VDD.n29 5.1393
R145 VDD.n29 VDD.n2 2.08185
R146 VDD.n2 VDD.n16 3.17392
R147 VDD.n17 VDD.n16 2.95516
R148 VDD.n2 VDD.n30 1.62567
R149 VDD.n31 VDD.t17 4.10365
R150 VDD.n31 VDD.n2 2.59967
R151 VDD.n7 VDD.n2 2.10895
R152 VDD.n44 VDD.t36 9.27784
R153 VDD.n21 VDD.t38 12.9305
R154 VDD.n23 VDD.t42 13.2046
R155 VDD.t4 VDD.n35 7.15344
R156 VDD.n1 VDD.t29 14.3857
R157 VDD.n40 VDD.n2 6.35555
R158 VDD VDD.n5 4.95014
R159 VDD.n40 VDD.n0 4.53045
R160 VDD.t54 VDD.n25 9.81636
R161 VDD.t108 VDD.n3 42.0706
R162 VDD.n27 VDD.t15 8.74756
R163 VDD.n32 VDD.n16 3.1434
R164 VDD.n38 VDD.t113 2.25932
R165 VDD.n36 VDD.t51 2.25932
R166 VDD.t67 VDD.n2 1.66305
R167 VDD.n9 VDD.t41 3.02739
R168 VDD.t23 VDD.t88 1.67895
R169 VDD.t109 VDD.t43 1.50638
R170 VDD.t114 VDD.t63 1.50638
R171 VDD VDD.n40 1.40591
R172 VDD.n37 VDD.t2 1.12991
R173 VDD.n34 VDD.t49 1.12991
R174 VDD.n28 VDD.t22 7.18106
R175 VDD.n34 VDD.t31 0.753441
R176 VDD.n18 VDD.t109 5.58981
R177 VDD.n4 VDD.n14 0.479667
R178 VDD.n42 VDD.t114 0.376971
R179 VDD.n15 VDD.t60 7.70884
R180 VDD.n2 VDD.n11 1.59858
R181 VDD.t98 VDD.n0 1.48207
R182 VDD.n5 VDD.n4 1.31821
R183 VDD.n8 VDD.t117 1.3081
R184 VDD.n14 VDD.n8 1.25218
R185 VDD.n2 VDD.n12 1.22069
R186 VDD.n0 VDD.n13 1.06113
R187 GND.t32 GND.n24 22665.9
R188 GND.t58 GND.t106 5315.71
R189 GND.t14 GND.t10 1652.11
R190 GND.t61 GND.t64 1584.67
R191 GND.t8 GND.t75 1584.67
R192 GND.t66 GND.t26 1584.67
R193 GND.t6 GND.t24 1584.67
R194 GND.t81 GND.t76 1584.67
R195 GND.t49 GND.t53 1517.24
R196 GND.n24 GND.t63 1348.66
R197 GND.n25 GND.t32 1196.93
R198 GND.n25 GND.t83 1180.08
R199 GND.t85 GND.t104 1078.49
R200 GND.t82 GND.t92 1011.49
R201 GND.t1 GND.t90 910.346
R202 GND.t17 GND.t22 910.346
R203 GND.t43 GND.t36 876.629
R204 GND.t34 GND.t18 876.629
R205 GND.t69 GND.t80 817.625
R206 GND.t27 GND.t29 809.196
R207 GND.t44 GND.t27 809.196
R208 GND.t0 GND.t62 809.196
R209 GND.t2 GND.t91 809.196
R210 GND.t35 GND.t43 741.763
R211 GND.t90 GND.t88 708.047
R212 GND.t29 GND.t52 708.047
R213 GND.t51 GND.t44 708.047
R214 GND.t62 GND.t30 708.047
R215 GND.t20 GND.t0 708.047
R216 GND.t91 GND.t38 708.047
R217 GND.t50 GND.t2 708.047
R218 GND.t36 GND.t54 708.047
R219 GND.t18 GND.t13 708.047
R220 GND.t59 GND.t61 708.047
R221 GND.t64 GND.t14 708.047
R222 GND.t26 GND.t6 708.047
R223 GND.t4 GND.t17 708.047
R224 GND.t92 GND.t94 708.047
R225 GND.t96 GND.t1 674.331
R226 GND.t7 GND.t40 674.331
R227 GND.t22 GND.t15 674.331
R228 GND.t21 GND.t78 674.331
R229 GND.t103 GND.t25 640.614
R230 GND.t63 GND.t59 606.898
R231 GND.t94 GND.t58 606.898
R232 GND.t55 GND.t46 573.181
R233 GND.t56 GND.t82 573.181
R234 GND.t104 GND.t34 557.268
R235 GND.t100 GND.t95 539.465
R236 GND.t87 GND.t85 481.877
R237 GND.t106 GND.t87 413.038
R238 GND.t10 GND.t69 396.17
R239 GND.t80 GND.t12 370.882
R240 GND.t41 GND.t8 370.882
R241 GND.t12 GND.t41 337.166
R242 GND.t95 GND.t83 168.583
R243 GND.t46 GND.t96 134.867
R244 GND.t52 GND.t55 134.867
R245 GND.t38 GND.t20 101.15
R246 GND.t88 GND.t100 67.4335
R247 GND.t30 GND.t51 67.4335
R248 GND.t53 GND.t50 67.4335
R249 GND.t54 GND.t49 67.4335
R250 GND.t25 GND.t35 67.4335
R251 GND.t13 GND.t103 67.4335
R252 GND.n5 GND.t98 0.657473
R253 GND.t74 GND.n4 7.88034
R254 GND.t47 GND.t98 7.22241
R255 GND.t33 GND.t98 6.86432
R256 GND.n21 GND.n22 45.1026
R257 GND.n2 GND.t42 7.46602
R258 GND.t60 GND.n3 6.50795
R259 GND.t31 GND.n1 32.7952
R260 GND.n16 GND.n17 46.7381
R261 GND.n3 GND.n2 1.02978
R262 GND.t75 GND.t7 33.717
R263 GND.t40 GND.t66 33.717
R264 GND.t24 GND.t4 33.717
R265 GND.t15 GND.t81 33.717
R266 GND.t76 GND.t21 33.717
R267 GND.t78 GND.t56 33.717
R268 GND.t11 GND.n18 32.7811
R269 GND.t3 GND.n1 34.3011
R270 GND.n16 GND.t37 32.7811
R271 GND.t5 GND.n6 33.4332
R272 GND.t84 GND.n11 31.2613
R273 GND.n15 GND.t31 5.42048
R274 GND.n9 GND.t37 7.20911
R275 GND.n11 GND.t89 5.2848
R276 GND.n12 GND.t89 29.4534
R277 GND.t45 GND.n15 29.8911
R278 GND.n24 GND.n2 605.931
R279 GND.t39 GND.t47 22.9652
R280 GND.t101 GND.n5 5.47229
R281 GND.t98 GND.t71 5.89277
R282 GND.n23 GND.t16 27.5105
R283 GND.n22 GND.t16 4.98285
R284 GND.t65 GND.n18 27.5105
R285 GND.n3 GND.t65 6.85822
R286 GND.n12 GND.t97 4.98285
R287 GND.t97 GND.n13 27.5105
R288 GND.n7 GND.t105 5.04761
R289 GND.t77 GND.t57 20.7064
R290 GND.t28 GND.n13 26.0046
R291 GND.t19 GND.n17 26.0046
R292 GND.n25 GND.n10 603.168
R293 GND.n14 GND.t45 3.98335
R294 GND.n19 GND.t70 17.844
R295 GND.n4 GND.t39 5.67855
R296 GND.n8 GND.n11 2.0091
R297 GND.n12 GND.n8 2.16007
R298 GND.n0 GND.n13 1.62567
R299 GND.n14 GND.t28 3.98335
R300 GND.n14 GND.n0 2.65982
R301 GND.n0 GND.n15 1.94126
R302 GND.n1 GND.n0 0.0538366
R303 GND.n9 GND.t3 7.20911
R304 GND.n16 GND.n0 1.62567
R305 GND.t86 GND.n17 1.62567
R306 GND.n7 GND.t19 6.77742
R307 GND.t84 GND.n10 4.04419
R308 GND.n8 GND.n10 2.62941
R309 GND.n2 GND.n18 1.62567
R310 GND.n19 GND.t11 5.42048
R311 GND.n19 GND.n2 1.94126
R312 GND.n2 GND.n20 1.62567
R313 GND.n21 GND.t5 5.48493
R314 GND.n21 GND.n2 1.90903
R315 GND.t93 GND.n22 2.16007
R316 GND.n23 GND.t93 1.62567
R317 GND.t42 GND.t9 8.65932
R318 GND.t57 GND.t93 6.69496
R319 GND.n7 GND.t86 0.383885
R320 GND.n26 GND.n2 6.49759
R321 GND.t70 GND.n20 12.4517
R322 GND GND.t98 5.00678
R323 GND.n26 GND.n8 4.6867
R324 GND GND.n26 1.84003
R325 GND.n5 GND.t72 6.63736
R326 GND.n23 GND.t77 6.80459
R327 GND.t23 GND.n6 6.67633
R328 GND.t9 GND.n20 6.80459
R329 GND.n2 GND.n6 1.48989
R330 GND.n0 GND.n8 1.31821
R331 GND.t93 GND.n2 1.19945
R332 GND.t86 GND.n0 1.19945
R333 GND.n4 GND.t98 1.04513
R334 GND.n0 GND.n9 1.03565
C0 VDD x4.Y 0.10743f
C1 VDD a_2283_823# 0.23335f
C2 x3.S x4.A1 0.17209f
C3 x2.Y VDD 0.20219f
C4 B[1] a_2007_199# 0.21961f
C5 VDD B[4] 0.48249f
C6 a_1131_1385# a_1387_1293# 0.1016f
C7 x2.S VDD 0.54942f
C8 x4.S x3.S 0.22089f
C9 VDD x9.Y 0.34211f
C10 VDD A[0] 0.2263f
C11 A[3] x4.S 0.12362f
C12 VDD x1.Y 0.17666f
C13 VDD x7.Y 0.11877f
C14 VDD a_1581_591# 0.12722f
C15 a_167_199# B[0] 0.22946f
C16 A[3] B[3] 0.16314f
C17 x2.S a_2007_199# 0.10357f
C18 LT GT 0.15314f
C19 a_139_2223# VDD 0.25287f
C20 x9.Y x11.Y 0.12941f
C21 A[1] B[1] 0.17579f
C22 VDD a_2007_199# 0.22815f
C23 x19.B a_1387_1293# 0.18924f
C24 a_845_591# a_957_591# 0.1016f
C25 a_139_911# x4.S 0.11208f
C26 VDD x11.Y 0.5313f
C27 x1.Y a_1223_1679# 0.12235f
C28 a_1499_2473# a_1755_2381# 0.1016f
C29 x2.S A[1] 0.13548f
C30 a_139_911# B[3] 0.21924f
C31 VDD a_1223_1679# 0.24256f
C32 x3.S x4.Y 0.18208f
C33 A[3] x4.Y 0.10435f
C34 a_2283_823# x3.S 0.10392f
C35 x2.Y x3.S 0.11644f
C36 x19.B EQ 0.10236f
C37 a_2325_2223# B[7] 0.11029f
C38 x2.S x3.S 0.15942f
C39 x10.C B[6] 0.14037f
C40 VDD a_1417_297# 0.24389f
C41 VDD A[1] 0.22683f
C42 x9.Y x3.S 0.16953f
C43 A[6] B[6] 0.19321f
C44 a_1693_591# x4.A1 0.14032f
C45 x10.C x10.D 0.41605f
C46 VDD a_957_591# 0.26685f
C47 x3.S a_1581_591# 0.16511f
C48 B[2] a_2283_823# 0.26408f
C49 a_1131_1385# VDD 0.23426f
C50 x19.B x10.B 0.14054f
C51 VDD x3.S 0.61789f
C52 B[7] x20.A1 0.11767f
C53 A[3] VDD 0.246f
C54 x10.C x10.B 0.26131f
C55 x10.A x19.B 0.22214f
C56 a_167_199# VDD 0.23106f
C57 x19.B x4.Y 0.1296f
C58 LT VDD 0.14609f
C59 A[2] VDD 0.13378f
C60 B[2] VDD 0.21218f
C61 VDD a_845_2223# 0.13099f
C62 a_1479_1653# x10.B 0.14018f
C63 VDD a_957_2473# 0.23975f
C64 VDD x19.B 0.49739f
C65 x10.C VDD 1.03008f
C66 x10.A x20.A1 0.16258f
C67 a_139_911# VDD 0.25348f
C68 a_810_47# B[0] 0.12996f
C69 a_1499_2473# VDD 0.24182f
C70 VDD A[6] 0.12169f
C71 EQ GT 0.26303f
C72 x6.Y B[6] 0.11169f
C73 a_1755_2381# x10.D 0.14515f
C74 B[2] a_2325_911# 0.10091f
C75 x10.C a_139_2223# 0.10722f
C76 a_845_591# x4.S 0.14754f
C77 B[5] a_2007_1911# 0.21916f
C78 x4.A1 x4.Y 0.15105f
C79 B[7] x10.D 0.14107f
C80 B[7] a_2283_2375# 0.25594f
C81 x2.Y x4.A1 0.2052f
C82 A[4] B[4] 0.26667f
C83 VDD a_1479_1653# 0.13368f
C84 x7.Y x20.A1 0.17201f
C85 A[3] x3.S 0.10712f
C86 A[7] B[7] 0.20139f
C87 x2.S x22.Y 0.17952f
C88 x6.Y A[5] 0.11065f
C89 VDD x20.A1 0.22147f
C90 a_1305_47# x2.S 0.16062f
C91 x10.A GT 0.18014f
C92 x10.B a_2007_1911# 0.12582f
C93 x2.S x4.S 0.12667f
C94 a_810_2045# B[4] 0.12583f
C95 x10.D a_2283_2375# 0.12387f
C96 a_1693_591# a_1581_591# 0.1016f
C97 VDD A[4] 0.21454f
C98 VDD a_1693_591# 0.25065f
C99 x2.S B[0] 0.10992f
C100 VDD x4.A1 0.22053f
C101 A[5] B[5] 0.16311f
C102 VDD x22.Y 0.39027f
C103 a_1305_47# VDD 0.11877f
C104 A[0] B[0] 0.2745f
C105 B[2] x3.S 0.12517f
C106 VDD a_1387_1293# 0.12302f
C107 VDD x4.S 0.42815f
C108 x1.Y x6.Y 0.17074f
C109 VDD a_1755_2381# 0.12774f
C110 VDD a_810_2045# 0.11626f
C111 VDD B[0] 0.24758f
C112 x7.Y x6.Y 0.10231f
C113 x10.A a_139_1999# 0.10198f
C114 VDD x6.Y 0.11146f
C115 VDD GT 0.23668f
C116 B[3] VDD 0.13414f
C117 x9.Y EQ 0.24462f
C118 VDD B[7] 0.22493f
C119 a_1479_1653# a_1223_1679# 0.1016f
C120 VDD a_2007_1911# 0.22704f
C121 B[2] A[2] 0.20258f
C122 a_139_1999# B[4] 0.29835f
C123 VDD B[5] 0.12121f
C124 a_810_47# VDD 0.11727f
C125 VDD EQ 0.45533f
C126 VDD B[6] 0.3248f
C127 a_845_2223# a_957_2473# 0.1016f
C128 x10.A B[4] 0.11094f
C129 VDD x10.D 0.55304f
C130 VDD a_2283_2375# 0.22647f
C131 a_139_2223# B[6] 0.32445f
C132 x10.C a_845_2223# 0.16387f
C133 x11.Y GT 0.13202f
C134 VDD a_139_1999# 0.25527f
C135 a_845_591# VDD 0.13475f
C136 x1.Y A[5] 0.10757f
C137 VDD B[1] 0.12533f
C138 VDD x10.B 0.47929f
C139 x22.Y a_1417_297# 0.14405f
C140 VDD A[7] 0.13013f
C141 a_1305_47# a_1417_297# 0.1016f
C142 VDD A[5] 0.23845f
C143 x10.A VDD 0.76322f
C144 x2.S x9.Y 0.14313f
C145 x11.Y EQ 0.12237f
C146 LT GND 0.29588f
C147 GT GND 0.45821f
C148 VDD GND 13.83444f
C149 a_2405_47# GND 0.1809f
C150 a_2049_47# GND 0.14107f
C151 a_1577_47# GND 0.2266f
C152 a_1411_47# GND 0.7612f
C153 a_209_47# GND 0.14753f
C154 a_317_297# GND 0.20731f
C155 a_1925_591# GND 0.13496f
C156 a_1693_591# GND 0.22474f
C157 a_2681_911# GND 0.10376f
C158 a_2325_911# GND 0.12992f
C159 a_1853_911# GND 0.13884f
C160 a_1687_911# GND 0.18902f
C161 a_1117_911# GND 0.4221f
C162 a_951_911# GND 0.20157f
C163 a_377_911# GND 0.12939f
C164 x4.A1 GND 0.11189f
C165 a_1297_1135# GND 0.28718f
C166 a_1131_1135# GND 0.29725f
C167 a_1308_1385# GND 0.23724f
C168 a_1131_1385# GND 0.65746f
C169 a_953_1385# GND 0.39573f
C170 a_201_1385# GND 0.22887f
C171 a_2049_1999# GND 0.41324f
C172 a_1389_1999# GND 0.46825f
C173 a_1223_1999# GND 0.22279f
C174 a_377_1999# GND 0.23472f
C175 a_221_1999# GND 0.20862f
C176 a_2325_2223# GND 0.22584f
C177 a_1665_2223# GND 0.28115f
C178 a_1499_2223# GND 0.13649f
C179 a_1117_2223# GND 0.13806f
C180 a_951_2223# GND 0.54276f
C181 a_377_2223# GND 0.28011f
C182 a_1676_2473# GND 0.12736f
C183 a_1499_2473# GND 0.329f
C184 a_1189_2473# GND 0.18225f
C185 a_957_2473# GND 0.33811f
C186 GND.t98 GND 0.17138f
C187 GND.t31 GND 0.30957f
C188 GND.t28 GND 0.15822f
C189 GND.t9 GND 0.38757f
C190 GND.t77 GND 0.28183f
C191 GND.t23 GND 0.27039f
C192 GND.t70 GND 0.14305f
C193 GND.t60 GND 0.19853f
C194 GND.t33 GND 0.54485f
C195 GND.t74 GND 0.12955f
C196 VDD.n0 GND 0.64511f
C197 VDD.n2 GND 0.87127f
C198 VDD.n5 GND 0.26325f
C199 VDD.n8 GND 0.29577f
C200 VDD.t66 GND 0.14781f
C201 VDD.t105 GND 0.10558f
C202 VDD.t107 GND 0.10071f
C203 VDD.t24 GND 0.12344f
C204 VDD.t19 GND 0.16324f
C205 VDD.t18 GND 0.13969f
C206 VDD.t5 GND 0.10517f
C207 VDD.t64 GND 0.11654f
C208 VDD.t76 GND 0.11654f
C209 VDD.t9 GND 0.10517f
C210 VDD.t13 GND 0.13969f
C211 VDD.t11 GND 0.16324f
C212 VDD.t16 GND 0.12344f
C213 VDD.t70 GND 0.10071f
C214 VDD.t68 GND 0.10558f
C215 VDD.t73 GND 0.14025f
C216 VDD.t25 GND 0.16465f
C217 VDD.t6 GND 0.16812f
C218 VDD.t10 GND 0.24222f
C219 VDD.t69 GND 0.13932f
C220 VDD.n33 GND 0.13944f
C221 VDD.t113 GND 0.17943f
C222 VDD.t51 GND 0.46271f
C223 VDD.t15 GND 0.12128f
C224 VDD.t98 GND 0.1722f
C225 VDD.t90 GND 0.11225f
C226 VDD.t22 GND 0.46778f
C227 VDD.t27 GND 0.20901f
C228 VDD.t49 GND 0.10198f
C229 VDD.t4 GND 0.7498f
C230 VDD.t54 GND 0.38252f
C231 VDD.t2 GND 0.24512f
C232 VDD.t81 GND 0.11035f
C233 VDD.t97 GND 0.14781f
C234 VDD.t91 GND 0.11841f
C235 VDD.t89 GND 0.14123f
C236 VDD.t48 GND 0.1432f
C237 VDD.t30 GND 0.14034f
C238 VDD.t57 GND 0.1389f
C239 VDD.t28 GND 0.1389f
C240 VDD.t59 GND 0.1074f
C241 VDD.t33 GND 0.1074f
C242 VDD.t0 GND 0.16826f
C243 VDD.t45 GND 0.13747f
C244 VDD.t78 GND 0.14606f
C245 VDD.t34 GND 0.16325f
C246 VDD.t82 GND 0.13747f
C247 VDD.t80 GND 0.14034f
C248 VDD.t99 GND 0.18247f
C249 VDD.n39 GND 0.25043f
C250 VDD.n40 GND 0.25876f
C251 VDD.t63 GND 0.28919f
C252 VDD.t101 GND 0.11238f
C253 VDD.t110 GND 0.11228f
C254 VDD.t41 GND 0.15897f
C255 VDD.t77 GND 0.16836f
C256 VDD.t42 GND 0.17022f
C257 VDD.t37 GND 0.2975f
C258 VDD.t84 GND 0.31787f
C259 VDD.t103 GND 0.39404f
C260 VDD.t43 GND 0.14212f
C261 VDD.t116 GND 0.14781f
C262 VDD.t36 GND 0.96181f
C263 VDD.t86 GND 0.69302f
C264 VDD.t39 GND 1.05897f
C265 VDD.n44 GND 1.02743f
.ends
